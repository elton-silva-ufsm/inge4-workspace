// Design: larissa/rom_v1
include "/apps/DESIGN_KITS/xh018/xfab/XKIT/xh018/cadence/v10_0/spectre/v10_0_2/lpmos/config.scs" section=default
include "/apps/DESIGN_KITS/xh018/xfab/XKIT/xh018/cadence/v10_0/spectre/v10_0_2/lpmos/param.scs" section=3s
include "/apps/DESIGN_KITS/xh018/xfab/XKIT/xh018/cadence/v10_0/spectre/v10_0_2/lpmos/bip.scs" section=tm
include "/apps/DESIGN_KITS/xh018/xfab/XKIT/xh018/cadence/v10_0/spectre/v10_0_2/lpmos/cap.scs" section=tm
include "/apps/DESIGN_KITS/xh018/xfab/XKIT/xh018/cadence/v10_0/spectre/v10_0_2/lpmos/dio.scs" section=tm
include "/apps/DESIGN_KITS/xh018/xfab/XKIT/xh018/cadence/v10_0/spectre/v10_0_2/lpmos/mos.scs" section=tm
include "/apps/DESIGN_KITS/xh018/xfab/XKIT/xh018/cadence/v10_0/spectre/v10_0_2/lpmos/photo.scs" section=tm
include "/apps/DESIGN_KITS/xh018/xfab/XKIT/xh018/cadence/v10_0/spectre/v10_0_2/lpmos/res.scs" section=tm

// larissa/column_decoder/schematic
subckt column_decoder BL\<15\> BL\<14\> BL\<13\> BL\<12\> BL\<11\> BL\<10\> BL\<9\> BL\<8\> BL\<7\> BL\<6\> BL\<5\> BL\<4\> BL\<3\> BL\<2\> BL\<1\> BL\<0\> BLE\<31\> BLE\<30\> BLE\<29\> BLE\<28\> BLE\<27\> BLE\<26\> BLE\<25\> BLE\<24\> BLE\<23\> BLE\<22\> BLE\<21\> BLE\<20\> BLE\<19\> BLE\<18\> BLE\<17\> BLE\<16\> BLE\<15\> BLE\<14\> BLE\<13\> BLE\<12\> BLE\<11\> BLE\<10\> BLE\<9\> BLE\<8\> BLE\<7\> BLE\<6\> BLE\<5\> BLE\<4\> BLE\<3\> BLE\<2\> BLE\<1\> BLE\<0\> SEL SELB
    M5\<15\> (BL\<15\> SELB BLE\<31\> 0) ne w=300n l=180.0n m=(1)*(1)
    M5\<14\> (BL\<14\> SELB BLE\<29\> 0) ne w=300n l=180.0n m=(1)*(1)
    M5\<13\> (BL\<13\> SELB BLE\<27\> 0) ne w=300n l=180.0n m=(1)*(1)
    M5\<12\> (BL\<12\> SELB BLE\<25\> 0) ne w=300n l=180.0n m=(1)*(1)
    M5\<11\> (BL\<11\> SELB BLE\<23\> 0) ne w=300n l=180.0n m=(1)*(1)
    M5\<10\> (BL\<10\> SELB BLE\<21\> 0) ne w=300n l=180.0n m=(1)*(1)
    M5\<9\> (BL\<9\> SELB BLE\<19\> 0) ne w=300n l=180.0n m=(1)*(1)
    M5\<8\> (BL\<8\> SELB BLE\<17\> 0) ne w=300n l=180.0n m=(1)*(1)
    M5\<7\> (BL\<7\> SELB BLE\<15\> 0) ne w=300n l=180.0n m=(1)*(1)
    M5\<6\> (BL\<6\> SELB BLE\<13\> 0) ne w=300n l=180.0n m=(1)*(1)
    M5\<5\> (BL\<5\> SELB BLE\<11\> 0) ne w=300n l=180.0n m=(1)*(1)
    M5\<4\> (BL\<4\> SELB BLE\<9\> 0) ne w=300n l=180.0n m=(1)*(1)
    M5\<3\> (BL\<3\> SELB BLE\<7\> 0) ne w=300n l=180.0n m=(1)*(1)
    M5\<2\> (BL\<2\> SELB BLE\<5\> 0) ne w=300n l=180.0n m=(1)*(1)
    M5\<1\> (BL\<1\> SELB BLE\<3\> 0) ne w=300n l=180.0n m=(1)*(1)
    M5\<0\> (BL\<0\> SELB BLE\<1\> 0) ne w=300n l=180.0n m=(1)*(1)
    M4\<15\> (BL\<15\> SEL BLE\<30\> 0) ne w=300n l=180.0n m=(1)*(1)
    M4\<14\> (BL\<14\> SEL BLE\<28\> 0) ne w=300n l=180.0n m=(1)*(1)
    M4\<13\> (BL\<13\> SEL BLE\<26\> 0) ne w=300n l=180.0n m=(1)*(1)
    M4\<12\> (BL\<12\> SEL BLE\<24\> 0) ne w=300n l=180.0n m=(1)*(1)
    M4\<11\> (BL\<11\> SEL BLE\<22\> 0) ne w=300n l=180.0n m=(1)*(1)
    M4\<10\> (BL\<10\> SEL BLE\<20\> 0) ne w=300n l=180.0n m=(1)*(1)
    M4\<9\> (BL\<9\> SEL BLE\<18\> 0) ne w=300n l=180.0n m=(1)*(1)
    M4\<8\> (BL\<8\> SEL BLE\<16\> 0) ne w=300n l=180.0n m=(1)*(1)
    M4\<7\> (BL\<7\> SEL BLE\<14\> 0) ne w=300n l=180.0n m=(1)*(1)
    M4\<6\> (BL\<6\> SEL BLE\<12\> 0) ne w=300n l=180.0n m=(1)*(1)
    M4\<5\> (BL\<5\> SEL BLE\<10\> 0) ne w=300n l=180.0n m=(1)*(1)
    M4\<4\> (BL\<4\> SEL BLE\<8\> 0) ne w=300n l=180.0n m=(1)*(1)
    M4\<3\> (BL\<3\> SEL BLE\<6\> 0) ne w=300n l=180.0n m=(1)*(1)
    M4\<2\> (BL\<2\> SEL BLE\<4\> 0) ne w=300n l=180.0n m=(1)*(1)
    M4\<1\> (BL\<1\> SEL BLE\<2\> 0) ne w=300n l=180.0n m=(1)*(1)
    M4\<0\> (BL\<0\> SEL BLE\<0\> 0) ne w=300n l=180.0n m=(1)*(1)
ends column_decoder

// GATES_HD/invr/schematic
subckt invr in out inh_ground_gnd inh_power_vdd
parameters GT_PDW GT_PDL=180.00n GT_PUW GT_PUL=180.00n
    ne (out in inh_ground_gnd inh_ground_gnd) ne w=GT_PDW l=GT_PDL m=(1)*(1)
    pe (out in inh_power_vdd inh_power_vdd) pe w=GT_PUW l=GT_PUL m=(1)*(1)
ends invr

// D_CELLS_HD/INHDX0/cmos_sch
subckt INHDX0 A Q inh_ground_gnd inh_power_vdd
    invr_1 (A Q inh_ground_gnd inh_power_vdd) invr GT_PDW=420.00n GT_PDL=180.00n GT_PUW=720.00n GT_PUL=180.000n
ends INHDX0

// larissa/rom_unit_0/schematic
subckt rom_unit_0 BL WL
    M0 (BL WL 0 0) ne w=220.0n l=180.0n m=(1)*(1)
ends rom_unit_0

// larissa/rom_unit_1/schematic
subckt rom_unit_1 BL WL
    M0 (net03 WL 0 0) ne w=220.0n l=180.0n m=(1)*(1)
ends rom_unit_1

// larissa/rom_matrix/schematic
subckt rom_matrix BLE\<31\> BLE\<30\> BLE\<29\> BLE\<28\> BLE\<27\> BLE\<26\> BLE\<25\> BLE\<24\> BLE\<23\> BLE\<22\> BLE\<21\> BLE\<20\> BLE\<19\> BLE\<18\> BLE\<17\> BLE\<16\> BLE\<15\> BLE\<14\> BLE\<13\> BLE\<12\> BLE\<11\> BLE\<10\> BLE\<9\> BLE\<8\> BLE\<7\> BLE\<6\> BLE\<5\> BLE\<4\> BLE\<3\> BLE\<2\> BLE\<1\> BLE\<0\> WL\<15\> WL\<14\> WL\<13\> WL\<12\> WL\<11\> WL\<10\> WL\<9\> WL\<8\> WL\<7\> WL\<6\> WL\<5\> WL\<4\> WL\<3\> WL\<2\> WL\<1\> WL\<0\>
    I47 (BLE\<15\> WL\<1\>) rom_unit_0
    I111 (BLE\<15\> WL\<3\>) rom_unit_0
    I223 (BLE\<31\> WL\<6\>) rom_unit_0
    I255 (BLE\<31\> WL\<7\>) rom_unit_0
    I287 (BLE\<31\> WL\<8\>) rom_unit_0
    I303 (BLE\<15\> WL\<9\>) rom_unit_0
    I319 (BLE\<31\> WL\<9\>) rom_unit_0
    I367 (BLE\<15\> WL\<11\>) rom_unit_0
    I383 (BLE\<31\> WL\<11\>) rom_unit_0
    I415 (BLE\<31\> WL\<12\>) rom_unit_0
    I463 (BLE\<15\> WL\<14\>) rom_unit_0
    I479 (BLE\<31\> WL\<14\>) rom_unit_0
    I495 (BLE\<15\> WL\<15\>) rom_unit_0
    I511 (BLE\<31\> WL\<15\>) rom_unit_0
    I14 (BLE\<14\> WL\<0\>) rom_unit_0
    I30 (BLE\<30\> WL\<0\>) rom_unit_0
    I46 (BLE\<14\> WL\<1\>) rom_unit_0
    I94 (BLE\<30\> WL\<2\>) rom_unit_0
    I110 (BLE\<14\> WL\<3\>) rom_unit_0
    I174 (BLE\<14\> WL\<5\>) rom_unit_0
    I190 (BLE\<30\> WL\<5\>) rom_unit_0
    I206 (BLE\<14\> WL\<6\>) rom_unit_0
    I222 (BLE\<30\> WL\<6\>) rom_unit_0
    I302 (BLE\<14\> WL\<9\>) rom_unit_0
    I334 (BLE\<14\> WL\<10\>) rom_unit_0
    I366 (BLE\<14\> WL\<11\>) rom_unit_0
    I382 (BLE\<30\> WL\<11\>) rom_unit_0
    I398 (BLE\<14\> WL\<12\>) rom_unit_0
    I446 (BLE\<30\> WL\<13\>) rom_unit_0
    I478 (BLE\<30\> WL\<14\>) rom_unit_0
    I494 (BLE\<14\> WL\<15\>) rom_unit_0
    I510 (BLE\<30\> WL\<15\>) rom_unit_0
    I13 (BLE\<13\> WL\<0\>) rom_unit_0
    I93 (BLE\<29\> WL\<2\>) rom_unit_0
    I125 (BLE\<29\> WL\<3\>) rom_unit_0
    I173 (BLE\<13\> WL\<5\>) rom_unit_0
    I189 (BLE\<29\> WL\<5\>) rom_unit_0
    I205 (BLE\<13\> WL\<6\>) rom_unit_0
    I221 (BLE\<29\> WL\<6\>) rom_unit_0
    I237 (BLE\<13\> WL\<7\>) rom_unit_0
    I269 (BLE\<13\> WL\<8\>) rom_unit_0
    I381 (BLE\<29\> WL\<11\>) rom_unit_0
    I429 (BLE\<13\> WL\<13\>) rom_unit_0
    I445 (BLE\<29\> WL\<13\>) rom_unit_0
    I477 (BLE\<29\> WL\<14\>) rom_unit_0
    I493 (BLE\<13\> WL\<15\>) rom_unit_0
    I509 (BLE\<29\> WL\<15\>) rom_unit_0
    I12 (BLE\<12\> WL\<0\>) rom_unit_0
    I28 (BLE\<28\> WL\<0\>) rom_unit_0
    I92 (BLE\<28\> WL\<2\>) rom_unit_0
    I108 (BLE\<12\> WL\<3\>) rom_unit_0
    I124 (BLE\<28\> WL\<3\>) rom_unit_0
    I172 (BLE\<12\> WL\<5\>) rom_unit_0
    I188 (BLE\<28\> WL\<5\>) rom_unit_0
    I204 (BLE\<12\> WL\<6\>) rom_unit_0
    I236 (BLE\<12\> WL\<7\>) rom_unit_0
    I268 (BLE\<12\> WL\<8\>) rom_unit_0
    I316 (BLE\<28\> WL\<9\>) rom_unit_0
    I332 (BLE\<12\> WL\<10\>) rom_unit_0
    I348 (BLE\<28\> WL\<10\>) rom_unit_0
    I412 (BLE\<28\> WL\<12\>) rom_unit_0
    I428 (BLE\<12\> WL\<13\>) rom_unit_0
    I444 (BLE\<28\> WL\<13\>) rom_unit_0
    I476 (BLE\<28\> WL\<14\>) rom_unit_0
    I492 (BLE\<12\> WL\<15\>) rom_unit_0
    I508 (BLE\<28\> WL\<15\>) rom_unit_0
    I11 (BLE\<11\> WL\<0\>) rom_unit_0
    I43 (BLE\<11\> WL\<1\>) rom_unit_0
    I59 (BLE\<27\> WL\<1\>) rom_unit_0
    I75 (BLE\<11\> WL\<2\>) rom_unit_0
    I91 (BLE\<27\> WL\<2\>) rom_unit_0
    I107 (BLE\<11\> WL\<3\>) rom_unit_0
    I139 (BLE\<11\> WL\<4\>) rom_unit_0
    I155 (BLE\<27\> WL\<4\>) rom_unit_0
    I171 (BLE\<11\> WL\<5\>) rom_unit_0
    I187 (BLE\<27\> WL\<5\>) rom_unit_0
    I203 (BLE\<11\> WL\<6\>) rom_unit_0
    I219 (BLE\<27\> WL\<6\>) rom_unit_0
    I235 (BLE\<11\> WL\<7\>) rom_unit_0
    I251 (BLE\<27\> WL\<7\>) rom_unit_0
    I267 (BLE\<11\> WL\<8\>) rom_unit_0
    I283 (BLE\<27\> WL\<8\>) rom_unit_0
    I299 (BLE\<11\> WL\<9\>) rom_unit_0
    I363 (BLE\<11\> WL\<11\>) rom_unit_0
    I395 (BLE\<11\> WL\<12\>) rom_unit_0
    I427 (BLE\<11\> WL\<13\>) rom_unit_0
    I443 (BLE\<27\> WL\<13\>) rom_unit_0
    I459 (BLE\<11\> WL\<14\>) rom_unit_0
    I475 (BLE\<27\> WL\<14\>) rom_unit_0
    I491 (BLE\<11\> WL\<15\>) rom_unit_0
    I507 (BLE\<27\> WL\<15\>) rom_unit_0
    I410 (BLE\<26\> WL\<12\>) rom_unit_0
    I474 (BLE\<26\> WL\<14\>) rom_unit_0
    I490 (BLE\<10\> WL\<15\>) rom_unit_0
    I506 (BLE\<26\> WL\<15\>) rom_unit_0
    I409 (BLE\<25\> WL\<12\>) rom_unit_0
    I473 (BLE\<25\> WL\<14\>) rom_unit_0
    I489 (BLE\<9\> WL\<15\>) rom_unit_0
    I505 (BLE\<25\> WL\<15\>) rom_unit_0
    I8 (BLE\<8\> WL\<0\>) rom_unit_0
    I24 (BLE\<24\> WL\<0\>) rom_unit_0
    I40 (BLE\<8\> WL\<1\>) rom_unit_0
    I56 (BLE\<24\> WL\<1\>) rom_unit_0
    I72 (BLE\<8\> WL\<2\>) rom_unit_0
    I88 (BLE\<24\> WL\<2\>) rom_unit_0
    I104 (BLE\<8\> WL\<3\>) rom_unit_0
    I120 (BLE\<24\> WL\<3\>) rom_unit_0
    I136 (BLE\<8\> WL\<4\>) rom_unit_0
    I152 (BLE\<24\> WL\<4\>) rom_unit_0
    I168 (BLE\<8\> WL\<5\>) rom_unit_0
    I184 (BLE\<24\> WL\<5\>) rom_unit_0
    I200 (BLE\<8\> WL\<6\>) rom_unit_0
    I216 (BLE\<24\> WL\<6\>) rom_unit_0
    I232 (BLE\<8\> WL\<7\>) rom_unit_0
    I248 (BLE\<24\> WL\<7\>) rom_unit_0
    I264 (BLE\<8\> WL\<8\>) rom_unit_0
    I280 (BLE\<24\> WL\<8\>) rom_unit_0
    I296 (BLE\<8\> WL\<9\>) rom_unit_0
    I312 (BLE\<24\> WL\<9\>) rom_unit_0
    I328 (BLE\<8\> WL\<10\>) rom_unit_0
    I344 (BLE\<24\> WL\<10\>) rom_unit_0
    I360 (BLE\<8\> WL\<11\>) rom_unit_0
    I376 (BLE\<24\> WL\<11\>) rom_unit_0
    I392 (BLE\<8\> WL\<12\>) rom_unit_0
    I408 (BLE\<24\> WL\<12\>) rom_unit_0
    I424 (BLE\<8\> WL\<13\>) rom_unit_0
    I440 (BLE\<24\> WL\<13\>) rom_unit_0
    I456 (BLE\<8\> WL\<14\>) rom_unit_0
    I472 (BLE\<24\> WL\<14\>) rom_unit_0
    I488 (BLE\<8\> WL\<15\>) rom_unit_0
    I504 (BLE\<24\> WL\<15\>) rom_unit_0
    I23 (BLE\<23\> WL\<0\>) rom_unit_0
    I55 (BLE\<23\> WL\<1\>) rom_unit_0
    I71 (BLE\<7\> WL\<2\>) rom_unit_0
    I87 (BLE\<23\> WL\<2\>) rom_unit_0
    I135 (BLE\<7\> WL\<4\>) rom_unit_0
    I167 (BLE\<7\> WL\<5\>) rom_unit_0
    I183 (BLE\<23\> WL\<5\>) rom_unit_0
    I199 (BLE\<7\> WL\<6\>) rom_unit_0
    I215 (BLE\<23\> WL\<6\>) rom_unit_0
    I231 (BLE\<7\> WL\<7\>) rom_unit_0
    I263 (BLE\<7\> WL\<8\>) rom_unit_0
    I311 (BLE\<23\> WL\<9\>) rom_unit_0
    I327 (BLE\<7\> WL\<10\>) rom_unit_0
    I487 (BLE\<7\> WL\<15\>) rom_unit_0
    I503 (BLE\<23\> WL\<15\>) rom_unit_0
    I6 (BLE\<6\> WL\<0\>) rom_unit_0
    I38 (BLE\<6\> WL\<1\>) rom_unit_0
    I54 (BLE\<22\> WL\<1\>) rom_unit_0
    I70 (BLE\<6\> WL\<2\>) rom_unit_0
    I102 (BLE\<6\> WL\<3\>) rom_unit_0
    I118 (BLE\<22\> WL\<3\>) rom_unit_0
    I150 (BLE\<22\> WL\<4\>) rom_unit_0
    I166 (BLE\<6\> WL\<5\>) rom_unit_0
    I214 (BLE\<22\> WL\<6\>) rom_unit_0
    I246 (BLE\<22\> WL\<7\>) rom_unit_0
    I278 (BLE\<22\> WL\<8\>) rom_unit_0
    I310 (BLE\<22\> WL\<9\>) rom_unit_0
    I326 (BLE\<6\> WL\<10\>) rom_unit_0
    I358 (BLE\<6\> WL\<11\>) rom_unit_0
    I374 (BLE\<22\> WL\<11\>) rom_unit_0
    I390 (BLE\<6\> WL\<12\>) rom_unit_0
    I422 (BLE\<6\> WL\<13\>) rom_unit_0
    I454 (BLE\<6\> WL\<14\>) rom_unit_0
    I470 (BLE\<22\> WL\<14\>) rom_unit_0
    I486 (BLE\<6\> WL\<15\>) rom_unit_0
    I502 (BLE\<22\> WL\<15\>) rom_unit_0
    I37 (BLE\<5\> WL\<1\>) rom_unit_0
    I85 (BLE\<21\> WL\<2\>) rom_unit_0
    I117 (BLE\<21\> WL\<3\>) rom_unit_0
    I133 (BLE\<5\> WL\<4\>) rom_unit_0
    I149 (BLE\<21\> WL\<4\>) rom_unit_0
    I181 (BLE\<21\> WL\<5\>) rom_unit_0
    I197 (BLE\<5\> WL\<6\>) rom_unit_0
    I213 (BLE\<21\> WL\<6\>) rom_unit_0
    I229 (BLE\<5\> WL\<7\>) rom_unit_0
    I245 (BLE\<21\> WL\<7\>) rom_unit_0
    I261 (BLE\<5\> WL\<8\>) rom_unit_0
    I277 (BLE\<21\> WL\<8\>) rom_unit_0
    I325 (BLE\<5\> WL\<10\>) rom_unit_0
    I357 (BLE\<5\> WL\<11\>) rom_unit_0
    I373 (BLE\<21\> WL\<11\>) rom_unit_0
    I389 (BLE\<5\> WL\<12\>) rom_unit_0
    I405 (BLE\<21\> WL\<12\>) rom_unit_0
    I437 (BLE\<21\> WL\<13\>) rom_unit_0
    I469 (BLE\<21\> WL\<14\>) rom_unit_0
    I485 (BLE\<5\> WL\<15\>) rom_unit_0
    I501 (BLE\<21\> WL\<15\>) rom_unit_0
    I36 (BLE\<4\> WL\<1\>) rom_unit_0
    I52 (BLE\<20\> WL\<1\>) rom_unit_0
    I84 (BLE\<20\> WL\<2\>) rom_unit_0
    I100 (BLE\<4\> WL\<3\>) rom_unit_0
    I148 (BLE\<20\> WL\<4\>) rom_unit_0
    I180 (BLE\<20\> WL\<5\>) rom_unit_0
    I196 (BLE\<4\> WL\<6\>) rom_unit_0
    I212 (BLE\<20\> WL\<6\>) rom_unit_0
    I244 (BLE\<20\> WL\<7\>) rom_unit_0
    I276 (BLE\<20\> WL\<8\>) rom_unit_0
    I308 (BLE\<20\> WL\<9\>) rom_unit_0
    I340 (BLE\<20\> WL\<10\>) rom_unit_0
    I356 (BLE\<4\> WL\<11\>) rom_unit_0
    I372 (BLE\<20\> WL\<11\>) rom_unit_0
    I388 (BLE\<4\> WL\<12\>) rom_unit_0
    I404 (BLE\<20\> WL\<12\>) rom_unit_0
    I420 (BLE\<4\> WL\<13\>) rom_unit_0
    I436 (BLE\<20\> WL\<13\>) rom_unit_0
    I452 (BLE\<4\> WL\<14\>) rom_unit_0
    I468 (BLE\<20\> WL\<14\>) rom_unit_0
    I484 (BLE\<4\> WL\<15\>) rom_unit_0
    I500 (BLE\<20\> WL\<15\>) rom_unit_0
    I3 (BLE\<3\> WL\<0\>) rom_unit_0
    I19 (BLE\<19\> WL\<0\>) rom_unit_0
    I35 (BLE\<3\> WL\<1\>) rom_unit_0
    I67 (BLE\<3\> WL\<2\>) rom_unit_0
    I115 (BLE\<19\> WL\<3\>) rom_unit_0
    I131 (BLE\<3\> WL\<4\>) rom_unit_0
    I147 (BLE\<19\> WL\<4\>) rom_unit_0
    I163 (BLE\<3\> WL\<5\>) rom_unit_0
    I227 (BLE\<3\> WL\<7\>) rom_unit_0
    I243 (BLE\<19\> WL\<7\>) rom_unit_0
    I259 (BLE\<3\> WL\<8\>) rom_unit_0
    I275 (BLE\<19\> WL\<8\>) rom_unit_0
    I291 (BLE\<3\> WL\<9\>) rom_unit_0
    I307 (BLE\<19\> WL\<9\>) rom_unit_0
    I323 (BLE\<3\> WL\<10\>) rom_unit_0
    I339 (BLE\<19\> WL\<10\>) rom_unit_0
    I355 (BLE\<3\> WL\<11\>) rom_unit_0
    I371 (BLE\<19\> WL\<11\>) rom_unit_0
    I387 (BLE\<3\> WL\<12\>) rom_unit_0
    I467 (BLE\<19\> WL\<14\>) rom_unit_0
    I483 (BLE\<3\> WL\<15\>) rom_unit_0
    I499 (BLE\<19\> WL\<15\>) rom_unit_0
    I482 (BLE\<2\> WL\<15\>) rom_unit_0
    I498 (BLE\<18\> WL\<15\>) rom_unit_0
    I481 (BLE\<1\> WL\<15\>) rom_unit_0
    I497 (BLE\<17\> WL\<15\>) rom_unit_0
    I0 (BLE\<0\> WL\<0\>) rom_unit_0
    I16 (BLE\<16\> WL\<0\>) rom_unit_0
    I32 (BLE\<0\> WL\<1\>) rom_unit_0
    I48 (BLE\<16\> WL\<1\>) rom_unit_0
    I64 (BLE\<0\> WL\<2\>) rom_unit_0
    I80 (BLE\<16\> WL\<2\>) rom_unit_0
    I96 (BLE\<0\> WL\<3\>) rom_unit_0
    I112 (BLE\<16\> WL\<3\>) rom_unit_0
    I128 (BLE\<0\> WL\<4\>) rom_unit_0
    I144 (BLE\<16\> WL\<4\>) rom_unit_0
    I160 (BLE\<0\> WL\<5\>) rom_unit_0
    I176 (BLE\<16\> WL\<5\>) rom_unit_0
    I192 (BLE\<0\> WL\<6\>) rom_unit_0
    I208 (BLE\<16\> WL\<6\>) rom_unit_0
    I224 (BLE\<0\> WL\<7\>) rom_unit_0
    I240 (BLE\<16\> WL\<7\>) rom_unit_0
    I256 (BLE\<0\> WL\<8\>) rom_unit_0
    I272 (BLE\<16\> WL\<8\>) rom_unit_0
    I288 (BLE\<0\> WL\<9\>) rom_unit_0
    I304 (BLE\<16\> WL\<9\>) rom_unit_0
    I320 (BLE\<0\> WL\<10\>) rom_unit_0
    I336 (BLE\<16\> WL\<10\>) rom_unit_0
    I352 (BLE\<0\> WL\<11\>) rom_unit_0
    I368 (BLE\<16\> WL\<11\>) rom_unit_0
    I384 (BLE\<0\> WL\<12\>) rom_unit_0
    I400 (BLE\<16\> WL\<12\>) rom_unit_0
    I416 (BLE\<0\> WL\<13\>) rom_unit_0
    I432 (BLE\<16\> WL\<13\>) rom_unit_0
    I448 (BLE\<0\> WL\<14\>) rom_unit_0
    I464 (BLE\<16\> WL\<14\>) rom_unit_0
    I480 (BLE\<0\> WL\<15\>) rom_unit_0
    I496 (BLE\<16\> WL\<15\>) rom_unit_0
    I15 (BLE\<15\> WL\<0\>) rom_unit_1
    I31 (BLE\<31\> WL\<0\>) rom_unit_1
    I63 (BLE\<31\> WL\<1\>) rom_unit_1
    I79 (BLE\<15\> WL\<2\>) rom_unit_1
    I95 (BLE\<31\> WL\<2\>) rom_unit_1
    I127 (BLE\<31\> WL\<3\>) rom_unit_1
    I143 (BLE\<15\> WL\<4\>) rom_unit_1
    I159 (BLE\<31\> WL\<4\>) rom_unit_1
    I175 (BLE\<15\> WL\<5\>) rom_unit_1
    I191 (BLE\<31\> WL\<5\>) rom_unit_1
    I207 (BLE\<15\> WL\<6\>) rom_unit_1
    I239 (BLE\<15\> WL\<7\>) rom_unit_1
    I271 (BLE\<15\> WL\<8\>) rom_unit_1
    I335 (BLE\<15\> WL\<10\>) rom_unit_1
    I351 (BLE\<31\> WL\<10\>) rom_unit_1
    I399 (BLE\<15\> WL\<12\>) rom_unit_1
    I431 (BLE\<15\> WL\<13\>) rom_unit_1
    I447 (BLE\<31\> WL\<13\>) rom_unit_1
    I62 (BLE\<30\> WL\<1\>) rom_unit_1
    I78 (BLE\<14\> WL\<2\>) rom_unit_1
    I126 (BLE\<30\> WL\<3\>) rom_unit_1
    I142 (BLE\<14\> WL\<4\>) rom_unit_1
    I158 (BLE\<30\> WL\<4\>) rom_unit_1
    I238 (BLE\<14\> WL\<7\>) rom_unit_1
    I254 (BLE\<30\> WL\<7\>) rom_unit_1
    I270 (BLE\<14\> WL\<8\>) rom_unit_1
    I286 (BLE\<30\> WL\<8\>) rom_unit_1
    I318 (BLE\<30\> WL\<9\>) rom_unit_1
    I350 (BLE\<30\> WL\<10\>) rom_unit_1
    I414 (BLE\<30\> WL\<12\>) rom_unit_1
    I430 (BLE\<14\> WL\<13\>) rom_unit_1
    I462 (BLE\<14\> WL\<14\>) rom_unit_1
    I29 (BLE\<29\> WL\<0\>) rom_unit_1
    I45 (BLE\<13\> WL\<1\>) rom_unit_1
    I61 (BLE\<29\> WL\<1\>) rom_unit_1
    I77 (BLE\<13\> WL\<2\>) rom_unit_1
    I109 (BLE\<13\> WL\<3\>) rom_unit_1
    I141 (BLE\<13\> WL\<4\>) rom_unit_1
    I157 (BLE\<29\> WL\<4\>) rom_unit_1
    I253 (BLE\<29\> WL\<7\>) rom_unit_1
    I285 (BLE\<29\> WL\<8\>) rom_unit_1
    I301 (BLE\<13\> WL\<9\>) rom_unit_1
    I317 (BLE\<29\> WL\<9\>) rom_unit_1
    I333 (BLE\<13\> WL\<10\>) rom_unit_1
    I349 (BLE\<29\> WL\<10\>) rom_unit_1
    I365 (BLE\<13\> WL\<11\>) rom_unit_1
    I397 (BLE\<13\> WL\<12\>) rom_unit_1
    I413 (BLE\<29\> WL\<12\>) rom_unit_1
    I461 (BLE\<13\> WL\<14\>) rom_unit_1
    I44 (BLE\<12\> WL\<1\>) rom_unit_1
    I60 (BLE\<28\> WL\<1\>) rom_unit_1
    I76 (BLE\<12\> WL\<2\>) rom_unit_1
    I140 (BLE\<12\> WL\<4\>) rom_unit_1
    I156 (BLE\<28\> WL\<4\>) rom_unit_1
    I220 (BLE\<28\> WL\<6\>) rom_unit_1
    I252 (BLE\<28\> WL\<7\>) rom_unit_1
    I284 (BLE\<28\> WL\<8\>) rom_unit_1
    I300 (BLE\<12\> WL\<9\>) rom_unit_1
    I364 (BLE\<12\> WL\<11\>) rom_unit_1
    I380 (BLE\<28\> WL\<11\>) rom_unit_1
    I396 (BLE\<12\> WL\<12\>) rom_unit_1
    I460 (BLE\<12\> WL\<14\>) rom_unit_1
    I27 (BLE\<27\> WL\<0\>) rom_unit_1
    I123 (BLE\<27\> WL\<3\>) rom_unit_1
    I315 (BLE\<27\> WL\<9\>) rom_unit_1
    I331 (BLE\<11\> WL\<10\>) rom_unit_1
    I347 (BLE\<27\> WL\<10\>) rom_unit_1
    I379 (BLE\<27\> WL\<11\>) rom_unit_1
    I411 (BLE\<27\> WL\<12\>) rom_unit_1
    I10 (BLE\<10\> WL\<0\>) rom_unit_1
    I26 (BLE\<26\> WL\<0\>) rom_unit_1
    I42 (BLE\<10\> WL\<1\>) rom_unit_1
    I58 (BLE\<26\> WL\<1\>) rom_unit_1
    I74 (BLE\<10\> WL\<2\>) rom_unit_1
    I90 (BLE\<26\> WL\<2\>) rom_unit_1
    I106 (BLE\<10\> WL\<3\>) rom_unit_1
    I122 (BLE\<26\> WL\<3\>) rom_unit_1
    I138 (BLE\<10\> WL\<4\>) rom_unit_1
    I154 (BLE\<26\> WL\<4\>) rom_unit_1
    I170 (BLE\<10\> WL\<5\>) rom_unit_1
    I186 (BLE\<26\> WL\<5\>) rom_unit_1
    I202 (BLE\<10\> WL\<6\>) rom_unit_1
    I218 (BLE\<26\> WL\<6\>) rom_unit_1
    I234 (BLE\<10\> WL\<7\>) rom_unit_1
    I250 (BLE\<26\> WL\<7\>) rom_unit_1
    I266 (BLE\<10\> WL\<8\>) rom_unit_1
    I282 (BLE\<26\> WL\<8\>) rom_unit_1
    I298 (BLE\<10\> WL\<9\>) rom_unit_1
    I314 (BLE\<26\> WL\<9\>) rom_unit_1
    I330 (BLE\<10\> WL\<10\>) rom_unit_1
    I346 (BLE\<26\> WL\<10\>) rom_unit_1
    I362 (BLE\<10\> WL\<11\>) rom_unit_1
    I378 (BLE\<26\> WL\<11\>) rom_unit_1
    I394 (BLE\<10\> WL\<12\>) rom_unit_1
    I426 (BLE\<10\> WL\<13\>) rom_unit_1
    I442 (BLE\<26\> WL\<13\>) rom_unit_1
    I458 (BLE\<10\> WL\<14\>) rom_unit_1
    I9 (BLE\<9\> WL\<0\>) rom_unit_1
    I25 (BLE\<25\> WL\<0\>) rom_unit_1
    I41 (BLE\<9\> WL\<1\>) rom_unit_1
    I57 (BLE\<25\> WL\<1\>) rom_unit_1
    I73 (BLE\<9\> WL\<2\>) rom_unit_1
    I89 (BLE\<25\> WL\<2\>) rom_unit_1
    I105 (BLE\<9\> WL\<3\>) rom_unit_1
    I121 (BLE\<25\> WL\<3\>) rom_unit_1
    I137 (BLE\<9\> WL\<4\>) rom_unit_1
    I153 (BLE\<25\> WL\<4\>) rom_unit_1
    I169 (BLE\<9\> WL\<5\>) rom_unit_1
    I185 (BLE\<25\> WL\<5\>) rom_unit_1
    I201 (BLE\<9\> WL\<6\>) rom_unit_1
    I217 (BLE\<25\> WL\<6\>) rom_unit_1
    I233 (BLE\<9\> WL\<7\>) rom_unit_1
    I249 (BLE\<25\> WL\<7\>) rom_unit_1
    I265 (BLE\<9\> WL\<8\>) rom_unit_1
    I281 (BLE\<25\> WL\<8\>) rom_unit_1
    I297 (BLE\<9\> WL\<9\>) rom_unit_1
    I313 (BLE\<25\> WL\<9\>) rom_unit_1
    I329 (BLE\<9\> WL\<10\>) rom_unit_1
    I345 (BLE\<25\> WL\<10\>) rom_unit_1
    I361 (BLE\<9\> WL\<11\>) rom_unit_1
    I377 (BLE\<25\> WL\<11\>) rom_unit_1
    I393 (BLE\<9\> WL\<12\>) rom_unit_1
    I425 (BLE\<9\> WL\<13\>) rom_unit_1
    I441 (BLE\<25\> WL\<13\>) rom_unit_1
    I457 (BLE\<9\> WL\<14\>) rom_unit_1
    I7 (BLE\<7\> WL\<0\>) rom_unit_1
    I39 (BLE\<7\> WL\<1\>) rom_unit_1
    I103 (BLE\<7\> WL\<3\>) rom_unit_1
    I119 (BLE\<23\> WL\<3\>) rom_unit_1
    I151 (BLE\<23\> WL\<4\>) rom_unit_1
    I247 (BLE\<23\> WL\<7\>) rom_unit_1
    I279 (BLE\<23\> WL\<8\>) rom_unit_1
    I295 (BLE\<7\> WL\<9\>) rom_unit_1
    I343 (BLE\<23\> WL\<10\>) rom_unit_1
    I359 (BLE\<7\> WL\<11\>) rom_unit_1
    I375 (BLE\<23\> WL\<11\>) rom_unit_1
    I391 (BLE\<7\> WL\<12\>) rom_unit_1
    I407 (BLE\<23\> WL\<12\>) rom_unit_1
    I423 (BLE\<7\> WL\<13\>) rom_unit_1
    I439 (BLE\<23\> WL\<13\>) rom_unit_1
    I455 (BLE\<7\> WL\<14\>) rom_unit_1
    I471 (BLE\<23\> WL\<14\>) rom_unit_1
    I22 (BLE\<22\> WL\<0\>) rom_unit_1
    I86 (BLE\<22\> WL\<2\>) rom_unit_1
    I134 (BLE\<6\> WL\<4\>) rom_unit_1
    I182 (BLE\<22\> WL\<5\>) rom_unit_1
    I198 (BLE\<6\> WL\<6\>) rom_unit_1
    I230 (BLE\<6\> WL\<7\>) rom_unit_1
    I262 (BLE\<6\> WL\<8\>) rom_unit_1
    I294 (BLE\<6\> WL\<9\>) rom_unit_1
    I342 (BLE\<22\> WL\<10\>) rom_unit_1
    I406 (BLE\<22\> WL\<12\>) rom_unit_1
    I438 (BLE\<22\> WL\<13\>) rom_unit_1
    I5 (BLE\<5\> WL\<0\>) rom_unit_1
    I21 (BLE\<21\> WL\<0\>) rom_unit_1
    I53 (BLE\<21\> WL\<1\>) rom_unit_1
    I69 (BLE\<5\> WL\<2\>) rom_unit_1
    I101 (BLE\<5\> WL\<3\>) rom_unit_1
    I165 (BLE\<5\> WL\<5\>) rom_unit_1
    I293 (BLE\<5\> WL\<9\>) rom_unit_1
    I309 (BLE\<21\> WL\<9\>) rom_unit_1
    I341 (BLE\<21\> WL\<10\>) rom_unit_1
    I421 (BLE\<5\> WL\<13\>) rom_unit_1
    I453 (BLE\<5\> WL\<14\>) rom_unit_1
    I4 (BLE\<4\> WL\<0\>) rom_unit_1
    I20 (BLE\<20\> WL\<0\>) rom_unit_1
    I68 (BLE\<4\> WL\<2\>) rom_unit_1
    I116 (BLE\<20\> WL\<3\>) rom_unit_1
    I132 (BLE\<4\> WL\<4\>) rom_unit_1
    I164 (BLE\<4\> WL\<5\>) rom_unit_1
    I228 (BLE\<4\> WL\<7\>) rom_unit_1
    I260 (BLE\<4\> WL\<8\>) rom_unit_1
    I292 (BLE\<4\> WL\<9\>) rom_unit_1
    I324 (BLE\<4\> WL\<10\>) rom_unit_1
    I51 (BLE\<19\> WL\<1\>) rom_unit_1
    I83 (BLE\<19\> WL\<2\>) rom_unit_1
    I99 (BLE\<3\> WL\<3\>) rom_unit_1
    I179 (BLE\<19\> WL\<5\>) rom_unit_1
    I195 (BLE\<3\> WL\<6\>) rom_unit_1
    I211 (BLE\<19\> WL\<6\>) rom_unit_1
    I403 (BLE\<19\> WL\<12\>) rom_unit_1
    I419 (BLE\<3\> WL\<13\>) rom_unit_1
    I435 (BLE\<19\> WL\<13\>) rom_unit_1
    I451 (BLE\<3\> WL\<14\>) rom_unit_1
    I2 (BLE\<2\> WL\<0\>) rom_unit_1
    I18 (BLE\<18\> WL\<0\>) rom_unit_1
    I34 (BLE\<2\> WL\<1\>) rom_unit_1
    I50 (BLE\<18\> WL\<1\>) rom_unit_1
    I66 (BLE\<2\> WL\<2\>) rom_unit_1
    I82 (BLE\<18\> WL\<2\>) rom_unit_1
    I98 (BLE\<2\> WL\<3\>) rom_unit_1
    I114 (BLE\<18\> WL\<3\>) rom_unit_1
    I130 (BLE\<2\> WL\<4\>) rom_unit_1
    I146 (BLE\<18\> WL\<4\>) rom_unit_1
    I162 (BLE\<2\> WL\<5\>) rom_unit_1
    I178 (BLE\<18\> WL\<5\>) rom_unit_1
    I194 (BLE\<2\> WL\<6\>) rom_unit_1
    I210 (BLE\<18\> WL\<6\>) rom_unit_1
    I226 (BLE\<2\> WL\<7\>) rom_unit_1
    I242 (BLE\<18\> WL\<7\>) rom_unit_1
    I258 (BLE\<2\> WL\<8\>) rom_unit_1
    I274 (BLE\<18\> WL\<8\>) rom_unit_1
    I290 (BLE\<2\> WL\<9\>) rom_unit_1
    I306 (BLE\<18\> WL\<9\>) rom_unit_1
    I322 (BLE\<2\> WL\<10\>) rom_unit_1
    I338 (BLE\<18\> WL\<10\>) rom_unit_1
    I354 (BLE\<2\> WL\<11\>) rom_unit_1
    I370 (BLE\<18\> WL\<11\>) rom_unit_1
    I386 (BLE\<2\> WL\<12\>) rom_unit_1
    I402 (BLE\<18\> WL\<12\>) rom_unit_1
    I418 (BLE\<2\> WL\<13\>) rom_unit_1
    I434 (BLE\<18\> WL\<13\>) rom_unit_1
    I450 (BLE\<2\> WL\<14\>) rom_unit_1
    I466 (BLE\<18\> WL\<14\>) rom_unit_1
    I1 (BLE\<1\> WL\<0\>) rom_unit_1
    I17 (BLE\<17\> WL\<0\>) rom_unit_1
    I33 (BLE\<1\> WL\<1\>) rom_unit_1
    I49 (BLE\<17\> WL\<1\>) rom_unit_1
    I65 (BLE\<1\> WL\<2\>) rom_unit_1
    I81 (BLE\<17\> WL\<2\>) rom_unit_1
    I97 (BLE\<1\> WL\<3\>) rom_unit_1
    I113 (BLE\<17\> WL\<3\>) rom_unit_1
    I129 (BLE\<1\> WL\<4\>) rom_unit_1
    I145 (BLE\<17\> WL\<4\>) rom_unit_1
    I161 (BLE\<1\> WL\<5\>) rom_unit_1
    I177 (BLE\<17\> WL\<5\>) rom_unit_1
    I193 (BLE\<1\> WL\<6\>) rom_unit_1
    I209 (BLE\<17\> WL\<6\>) rom_unit_1
    I225 (BLE\<1\> WL\<7\>) rom_unit_1
    I241 (BLE\<17\> WL\<7\>) rom_unit_1
    I257 (BLE\<1\> WL\<8\>) rom_unit_1
    I273 (BLE\<17\> WL\<8\>) rom_unit_1
    I289 (BLE\<1\> WL\<9\>) rom_unit_1
    I305 (BLE\<17\> WL\<9\>) rom_unit_1
    I321 (BLE\<1\> WL\<10\>) rom_unit_1
    I337 (BLE\<17\> WL\<10\>) rom_unit_1
    I353 (BLE\<1\> WL\<11\>) rom_unit_1
    I369 (BLE\<17\> WL\<11\>) rom_unit_1
    I385 (BLE\<1\> WL\<12\>) rom_unit_1
    I401 (BLE\<17\> WL\<12\>) rom_unit_1
    I417 (BLE\<1\> WL\<13\>) rom_unit_1
    I433 (BLE\<17\> WL\<13\>) rom_unit_1
    I449 (BLE\<1\> WL\<14\>) rom_unit_1
    I465 (BLE\<17\> WL\<14\>) rom_unit_1
ends rom_matrix

// GATES_HD/nor2/schematic
subckt nor2 a b out inh_ground_gnd inh_power_vdd
parameters GT_PDW GT_PDL=180.00n GT_PUW GT_PUL=180.00n
    MN1 (out b inh_ground_gnd inh_ground_gnd) ne w=GT_PDW l=GT_PDL m=(1)*(1)
    MN2 (out a inh_ground_gnd inh_ground_gnd) ne w=GT_PDW l=GT_PDL m=(1)*(1)
    MP1 (out a net14 inh_power_vdd) pe w=GT_PUW l=GT_PUL m=(1)*(1)
    MP2 (net14 b inh_power_vdd inh_power_vdd) pe w=GT_PUW l=GT_PUL m=(1)*(1)
ends nor2

// D_CELLS_HD/NO2HDX0/cmos_sch
subckt NO2HDX0 A B Q inh_ground_gnd inh_power_vdd
    nor2_1 (A B Q inh_ground_gnd inh_power_vdd) nor2 GT_PDW=420.00n GT_PDL=180.00n GT_PUW=720.00n GT_PUL=180.00n
ends NO2HDX0

// D_CELLS_HD/NO2I1HDX0/cmos_sch
subckt NO2I1HDX0 AN B Q inh_ground_gnd inh_power_vdd
    nor2_1 (net12 B Q inh_ground_gnd inh_power_vdd) nor2 GT_PDW=420.00n GT_PDL=180.00n GT_PUW=720.00n GT_PUL=180.00n
    invr_1 (AN net12 inh_ground_gnd inh_power_vdd) invr GT_PDW=420.00n GT_PDL=180.00n GT_PUW=720.0n GT_PUL=180.00n
ends NO2I1HDX0

// GATES_HD/nand2/schematic
subckt nand2 a b out inh_ground_gnd inh_power_vdd
parameters GT_PDW GT_PDL=180.00n GT_PUW GT_PUL=180.00n
    MN1 (out a net11 inh_ground_gnd) ne w=GT_PDW l=GT_PDL m=(1)*(1)
    MN2 (net11 b inh_ground_gnd inh_ground_gnd) ne w=GT_PDW l=GT_PDL m=(1)*(1)
    MP1 (out a inh_power_vdd inh_power_vdd) pe w=GT_PUW l=GT_PUL m=(1)*(1)
    MP2 (out b inh_power_vdd inh_power_vdd) pe w=GT_PUW l=GT_PUL m=(1)*(1)
ends nand2

// D_CELLS_HD/AND2HDX0/cmos_sch
subckt AND2HDX0 A B Q inh_ground_gnd inh_power_vdd
    invr_1 (net10 Q inh_ground_gnd inh_power_vdd) invr GT_PDW=420.00n GT_PDL=180.00n GT_PUW=720.00n GT_PUL=180.00n
    nand2_1 (A B net10 inh_ground_gnd inh_power_vdd) nand2 GT_PDW=420.00n GT_PDL=180.00n GT_PUW=720.00n GT_PUL=180.00n
ends AND2HDX0

// D_CELLS_HD/NA2I1HDX0/cmos_sch
subckt NA2I1HDX0 AN B Q inh_ground_gnd inh_power_vdd
    nand2_1 (net4 B Q inh_ground_gnd inh_power_vdd) nand2 GT_PDW=420.0n GT_PDL=180.00n GT_PUW=720.00n GT_PUL=180.00n
    invr_1 (AN net4 inh_ground_gnd inh_power_vdd) invr GT_PDW=420.00n GT_PDL=180.00n GT_PUW=720.0n GT_PUL=180.00n
ends NA2I1HDX0

// D_CELLS_HD/NA2HDX0/cmos_sch
subckt NA2HDX0 A B Q inh_ground_gnd inh_power_vdd
    nand2_1 (A B Q inh_ground_gnd inh_power_vdd) nand2 GT_PDW=420.0n GT_PDL=180.00n GT_PUW=720.00n GT_PUL=180.00n
ends NA2HDX0

// larissa/dmux1x16/schematic
subckt dmux1x16 IN ADR\<3\> ADR\<2\> ADR\<1\> ADR\<0\> WL\<15\> WL\<14\> WL\<13\> WL\<12\> WL\<11\> WL\<10\> WL\<9\> WL\<8\> WL\<7\> WL\<6\> WL\<5\> WL\<4\> WL\<3\> WL\<2\> WL\<1\> WL\<0\> inh_ground_gnd inh_power_vdd
    g347__2398 (n_18 n_32 WL\<7\> inh_ground_gnd inh_power_vdd) NO2HDX0
    g350__5107 (n_20 n_32 WL\<5\> inh_ground_gnd inh_power_vdd) NO2HDX0
    g358__6161 (ADR\<0\> n_0 n_5 inh_ground_gnd inh_power_vdd) NO2HDX0
    g362__2883 (ADR\<1\> ADR\<2\> n_11 inh_ground_gnd inh_power_vdd) NO2HDX0
    g351__6260 (n_14 n_32 WL\<3\> inh_ground_gnd inh_power_vdd) NO2HDX0
    g357__7482 (ADR\<0\> n_2 n_9 inh_ground_gnd inh_power_vdd) NO2HDX0
    g355__8428 (n_20 n_17 WL\<13\> inh_ground_gnd inh_power_vdd) NO2HDX0
    g354__3680 (n_14 n_17 WL\<11\> inh_ground_gnd inh_power_vdd) NO2HDX0
    g344__5526 (n_18 n_17 WL\<15\> inh_ground_gnd inh_power_vdd) NO2HDX0
    g346__7098 (n_5 n_20 WL\<4\> inh_ground_gnd inh_power_vdd) NO2I1HDX0
    g349__6783 (n_5 n_18 WL\<6\> inh_ground_gnd inh_power_vdd) NO2I1HDX0
    g348__6131 (n_5 n_14 WL\<2\> inh_ground_gnd inh_power_vdd) NO2I1HDX0
    g353__4319 (n_11 n_32 WL\<1\> inh_ground_gnd inh_power_vdd) NO2I1HDX0
    g352__8246 (n_9 n_20 WL\<12\> inh_ground_gnd inh_power_vdd) NO2I1HDX0
    g340__2802 (n_11 n_17 WL\<9\> inh_ground_gnd inh_power_vdd) NO2I1HDX0
    g341__1705 (n_9 n_18 WL\<14\> inh_ground_gnd inh_power_vdd) NO2I1HDX0
    g343__1617 (n_9 n_14 WL\<10\> inh_ground_gnd inh_power_vdd) NO2I1HDX0
    g342__1881 (n_5 n_11 WL\<0\> inh_ground_gnd inh_power_vdd) AND2HDX0
    g345__5122 (n_9 n_11 WL\<8\> inh_ground_gnd inh_power_vdd) AND2HDX0
    g365__2346 (ADR\<3\> IN n_0 inh_ground_gnd inh_power_vdd) NA2I1HDX0
    g2 (n_0 ADR\<0\> n_32 inh_ground_gnd inh_power_vdd) NA2I1HDX0
    g360__1666 (ADR\<1\> ADR\<2\> n_20 inh_ground_gnd inh_power_vdd) NA2I1HDX0
    g361__9945 (ADR\<2\> ADR\<1\> n_14 inh_ground_gnd inh_power_vdd) NA2I1HDX0
    g356__4733 (n_2 ADR\<0\> n_17 inh_ground_gnd inh_power_vdd) NA2I1HDX0
    g364__9315 (IN ADR\<3\> n_2 inh_ground_gnd inh_power_vdd) NA2HDX0
    g366__7410 (ADR\<2\> ADR\<1\> n_18 inh_ground_gnd inh_power_vdd) NA2HDX0
ends dmux1x16

// larissa/rom_v1/schematic
I26 (BL\<15\> BL\<14\> BL\<13\> BL\<12\> BL\<11\> BL\<10\> BL\<9\> BL\<8\> BL\<7\> BL\<6\> BL\<5\> BL\<4\> BL\<3\> BL\<2\> BL\<1\> BL\<0\> BLE\<31\> BLE\<30\> BLE\<29\> BLE\<28\> BLE\<27\> BLE\<26\> BLE\<25\> BLE\<24\> BLE\<23\> BLE\<22\> BLE\<21\> BLE\<20\> BLE\<19\> BLE\<18\> BLE\<17\> BLE\<16\> BLE\<15\> BLE\<14\> BLE\<13\> BLE\<12\> BLE\<11\> BLE\<10\> BLE\<9\> BLE\<8\> BLE\<7\> BLE\<6\> BLE\<5\> BLE\<4\> BLE\<3\> BLE\<2\> BLE\<1\> BLE\<0\> ADDR\<4\> net6) column_decoder
I32 (ADDR\<4\> net6 0 vdd!) INHDX0
M0\<15\> (BL\<15\> 0 vdd! vdd!) pe w=220.0n l=3.3u m=(1)*(1)
M0\<14\> (BL\<14\> 0 vdd! vdd!) pe w=220.0n l=3.3u m=(1)*(1)
M0\<13\> (BL\<13\> 0 vdd! vdd!) pe w=220.0n l=3.3u m=(1)*(1)
M0\<12\> (BL\<12\> 0 vdd! vdd!) pe w=220.0n l=3.3u m=(1)*(1)
M0\<11\> (BL\<11\> 0 vdd! vdd!) pe w=220.0n l=3.3u m=(1)*(1)
M0\<10\> (BL\<10\> 0 vdd! vdd!) pe w=220.0n l=3.3u m=(1)*(1)
M0\<9\> (BL\<9\> 0 vdd! vdd!) pe w=220.0n l=3.3u m=(1)*(1)
M0\<8\> (BL\<8\> 0 vdd! vdd!) pe w=220.0n l=3.3u m=(1)*(1)
M0\<7\> (BL\<7\> 0 vdd! vdd!) pe w=220.0n l=3.3u m=(1)*(1)
M0\<6\> (BL\<6\> 0 vdd! vdd!) pe w=220.0n l=3.3u m=(1)*(1)
M0\<5\> (BL\<5\> 0 vdd! vdd!) pe w=220.0n l=3.3u m=(1)*(1)
M0\<4\> (BL\<4\> 0 vdd! vdd!) pe w=220.0n l=3.3u m=(1)*(1)
M0\<3\> (BL\<3\> 0 vdd! vdd!) pe w=220.0n l=3.3u m=(1)*(1)
M0\<2\> (BL\<2\> 0 vdd! vdd!) pe w=220.0n l=3.3u m=(1)*(1)
M0\<1\> (BL\<1\> 0 vdd! vdd!) pe w=220.0n l=3.3u m=(1)*(1)
M0\<0\> (BL\<0\> 0 vdd! vdd!) pe w=220.0n l=3.3u m=(1)*(1)
I23 (BLE\<31\> BLE\<30\> BLE\<29\> BLE\<28\> BLE\<27\> BLE\<26\> BLE\<25\> BLE\<24\> BLE\<23\> BLE\<22\> BLE\<21\> BLE\<20\> BLE\<19\> BLE\<18\> BLE\<17\> BLE\<16\> BLE\<15\> BLE\<14\> BLE\<13\> BLE\<12\> BLE\<11\> BLE\<10\> BLE\<9\> BLE\<8\> BLE\<7\> BLE\<6\> BLE\<5\> BLE\<4\> BLE\<3\> BLE\<2\> BLE\<1\> BLE\<0\> net08\<0\> net08\<1\> net08\<2\> net08\<3\> net08\<4\> net08\<5\> net08\<6\> net08\<7\> net08\<8\> net08\<9\> net08\<10\> net08\<11\> net08\<12\> net08\<13\> net08\<14\> net08\<15\>) rom_matrix
I0 (IN ADDR\<3\> ADDR\<2\> ADDR\<1\> ADDR\<0\> net08\<0\> net08\<1\> net08\<2\> net08\<3\> net08\<4\> net08\<5\> net08\<6\> net08\<7\> net08\<8\> net08\<9\> net08\<10\> net08\<11\> net08\<12\> net08\<13\> net08\<14\> net08\<15\> 0 vdd!) dmux1x16
